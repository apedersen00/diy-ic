** sch_path: /home/andre/diy-ic/testbench/two_stage_tb.sch
**.subckt two_stage_tb
C2 voutp GND 100f m=1
V2 vdd GND DC 3.3
V4 vinp GND DC 1.65 AC 1.0
L9 voutp vinm 4G m=1
C3 vinm GND 4G m=1
x1 net5 voutp vinp vinm GND net1 two_stage
I0 net1 GND 10u
C1 voutp_cmrr GND 100f m=1
x2 vdd voutp_cmrr vinp vinp GND net2 two_stage
I1 net2 GND 10u
C4 voutp_psrr GND 100f m=1
x3 vdd_ac voutp_psrr net3 net3 GND net4 two_stage
I2 net4 GND 10u
V1 net3 GND DC 1.65
V3 vdd_ac GND DC 3.30 AC 1.0
V5 net5 GND DC 3.3
**** begin user architecture code

.lib cornerMOShv.lib mos_tt
.lib /home/andre/os_eda/IHP-Open-PDK/ihp-sg13g2/libs.tech/ngspice/models/cornerCAP.lib cap_typ

.param temp=27
.include two_stage_tb.save
.control
op
save all
print i(V5)
write two_stage_tb.raw
set appendwrite #writing into the same raw file
ac dec 100 1 100e6
save all

let Av = db(v(voutp))
let phase = 180/3.14*vp(voutp)
let CMRR = db((v(voutp)/v(vinp))/(v(voutp_cmrr)/v(vinp)))
let PSRR = db(v(voutp_psrr)/v(vdd_ac))

echo ---
meas ac gm_db find vdb(voutp) when vp(voutp)=0
meas ac pm_deg find phase when vdb(voutp)=0
meas ac _3db_f when phase=-45
meas ac _0db_f when vdb(voutp)=0
meas ac dc_gain find vdb(voutp) at=1
echo ---

write two_stage_tb.raw
.endc

**** end user architecture code
**.ends

* expanding   symbol:  two_stage.sym # of pins=6
** sym_path: /home/andre/diy-ic/schematic/two_stage.sym
** sch_path: /home/andre/diy-ic/schematic/two_stage.sch
.subckt two_stage vdd out v+ v- vss iout
*.opin out
*.ipin iout
*.ipin v-
*.ipin v+
*.ipin vdd
*.ipin vss
XM1 net2 v- net1 vdd sg13_hv_pmos w=23.0u l=5.0u ng=5 m=1
XM2 net3 v+ net1 vdd sg13_hv_pmos w=23.0u l=5.0u ng=5 m=1
XM5 mirror vb_n net5 vss sg13_hv_nmos w=0.370u l=2.0u ng=1 m=1
XM11 net1 iout vdd vdd sg13_hv_pmos w=1.0u l=5.0u ng=1 m=1
XM12 iout iout vdd vdd sg13_hv_pmos w=8.5u l=5.0u ng=1 m=1
XM3 mirror vb_p net2 vdd sg13_hv_pmos w=1.3u l=1.0u ng=1 m=1
XM4 net4 vb_p net3 vdd sg13_hv_pmos w=1.3u l=1.0u ng=1 m=1
XM6 net4 vb_n net6 vss sg13_hv_nmos w=0.370u l=2.0u ng=1 m=1
XM7 net5 mirror vss vss sg13_hv_nmos w=0.370u l=2.0u ng=1 m=1
XM8 net6 mirror vss vss sg13_hv_nmos w=0.370u l=2.0u ng=1 m=1
XM9 out net4 vss vss sg13_hv_nmos w=2.0u l=1.00u ng=1 m=1
XC1 net4 out cap_cmim w=14.0e-6 l=14.0e-6 m=1
XM10 out iout vdd vdd sg13_hv_pmos w=8.0u l=1.0u ng=1 m=1
V1 vb_p vss 1.0
V2 vb_n vss 1.6
.ends

.GLOBAL GND
.end
