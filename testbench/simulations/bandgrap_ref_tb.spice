** sch_path: /home/andre/diy-ic/testbench/bandgrap_ref_tb.sch
**.subckt bandgrap_ref_tb
V2 vdd GND DC 3.3
x1 vdd voutp vinp vinm GND net1 two_stage
I0 net1 GND 10u
x2 vdd voutp vbgr vinp vinm GND bandgap_ref
XM1 net2 vinm GND GND sg13_hv_nmos w=150n l=10.0u ng=1 m=1
XM2 net2 net2 vdd vdd sg13_hv_pmos w=1.0u l=1.0u ng=1 m=1
XM3 net3 net2 vdd vdd sg13_hv_pmos w=1.0u l=1.0u ng=1 m=1
XC1 net3 GND cap_cmim w=18.0e-6 l=18.0e-6 m=1
XM4 vinm net3 vdd vdd sg13_hv_pmos w=200n l=4.0u ng=1 m=1
C2 voutp GND 100f m=1
C3 vbgr GND 100f m=1
C4 vinp GND 1f m=1
**** begin user architecture code

.lib cornerMOShv.lib mos_tt
.lib /home/andre/os_eda/IHP-Open-PDK/ihp-sg13g2/libs.tech/ngspice/models/cornerCAP.lib cap_typ
.lib /home/andre/os_eda/IHP-Open-PDK/ihp-sg13g2/libs.tech/ngspice/models/cornerRES.lib res_typ

.param temp=27
.control
.include bandgrap_ref_tb.save
.save all
alter V2 dc 3.3
op
dc TEMP -50 100 5
write bgr_temp.raw
.endc

.control
.save all
tran 1m 2
write bgr_tran.raw
.endc

**** end user architecture code
**.ends

* expanding   symbol:  two_stage.sym # of pins=6
** sym_path: /home/andre/diy-ic/schematic/two_stage.sym
** sch_path: /home/andre/diy-ic/schematic/two_stage.sch
.subckt two_stage vdd out v+ v- vss iout
*.opin out
*.ipin iout
*.ipin v-
*.ipin v+
*.ipin vdd
*.ipin vss
XM1 net2 v- net1 vdd sg13_hv_pmos w=23.0u l=5.0u ng=5 m=1
XM2 net3 v+ net1 vdd sg13_hv_pmos w=23.0u l=5.0u ng=5 m=1
XM5 mirror vb_n net5 vss sg13_hv_nmos w=0.370u l=2.0u ng=1 m=1
XM11 net1 iout vdd vdd sg13_hv_pmos w=1.0u l=5.0u ng=1 m=1
XM12 iout iout vdd vdd sg13_hv_pmos w=8.5u l=5.0u ng=1 m=1
XM3 mirror vb_p net2 vdd sg13_hv_pmos w=1.3u l=1.0u ng=1 m=1
XM4 net4 vb_p net3 vdd sg13_hv_pmos w=1.3u l=1.0u ng=1 m=1
XM6 net4 vb_n net6 vss sg13_hv_nmos w=0.370u l=2.0u ng=1 m=1
XM7 net5 mirror vss vss sg13_hv_nmos w=0.370u l=2.0u ng=1 m=1
XM8 net6 mirror vss vss sg13_hv_nmos w=0.370u l=2.0u ng=1 m=1
XM9 out net4 vss vss sg13_hv_nmos w=2.0u l=1.00u ng=1 m=1
XC1 net4 out cap_cmim w=14.0e-6 l=14.0e-6 m=1
XM10 out iout vdd vdd sg13_hv_pmos w=8.0u l=1.0u ng=1 m=1
V1 vb_p vss 1.0
V2 vb_n vss 1.6
.ends

* expanding   symbol:  bandgap_ref.sym # of pins=6
** sym_path: /home/andre/diy-ic/schematic/bandgap_ref.sym
** sch_path: /home/andre/diy-ic/schematic/bandgap_ref.sch
.subckt bandgap_ref vdd vo vbgr v+ v- vss
*.ipin vdd
*.ipin vss
*.ipin vo
*.opin vbgr
*.ipin v+
*.ipin v-
XM1 net1 net1 vss vss sg13_hv_nmos w=7.0u l=5.0u ng=1 m=1
XM2 v- v+ vss vss sg13_hv_nmos w=7.0u l=5.0u ng=1 m=1
XM3 v- vo vdd vdd sg13_hv_pmos w=15.0u l=5.0u ng=5 m=1
XM4 v+ vo vdd vdd sg13_hv_pmos w=15.0u l=5.0u ng=5 m=1
XR1 net1 v+ rppd w=0.5e-6 l=200e-6 m=1 b=0
XM5 vbgr vo vdd vdd sg13_hv_pmos w=15.0u l=5.0u ng=5 m=1
XR3 vss v+ rppd w=0.5e-6 l=200e-6 m=1 b=0
XR4 vss vbgr rppd w=0.5e-6 l=200e-6 m=1 b=0
XC1 vbgr vss cap_cmim w=7.0e-6 l=7.0e-6 m=1
.ends

.GLOBAL GND
.end
